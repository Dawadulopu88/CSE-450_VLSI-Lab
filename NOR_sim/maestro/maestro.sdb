ADE simulation setup
Run mode: Single Run, Sweeps and Corners
Tests:
  Lab_NOR_sim_1: Lab/NOR_sim/schematic, simulator spectre
    Outputs: /Vout; /Va; /Vb
